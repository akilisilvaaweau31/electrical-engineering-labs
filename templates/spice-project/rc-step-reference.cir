* Original educational reference source; not executed during setup.
* 10 kohm and 1 uF give a nominal 10 ms time constant.
* The analytical example assumes an ideal 3.3 V step; this source uses a 1 ns rise.
Vstep in 0 PULSE(0 3.3 0 1n 1n 100m 200m)
R1 in out 10k
C1 out 0 1u
.tran 0 50m 0 10u
.end
